* PMOS OFF: single-transistor leakage characterisation (Vg = VDD, Vb = VDD)

.include ../../models/32nm_HP.pm
.options gmin=1e-18 abstol=1e-18 reltol=1e-6 vntol=1e-9

* Sample
.param vdd=0.943800 temp=46.4646 w=226.036n vd=0.822072 vs=0.738409
.param vth0=-0.539131 toxe=1.22089n ndep=3.21809e18 u0=0.0128180 xj=9.83414n
.param ldiff=64n
.csparam temp={temp} vth0={vth0} toxe={toxe} ndep={ndep} u0={u0} xj={xj}

M1 d g s b pmos W={w} L=32n AD={w*ldiff} AS={w*ldiff} PD={2*(w+ldiff)} PS={2*(w+ldiff)}
Vd d 0 dc {vd}
Vg g 0 dc {vdd}
Vs s 0 dc {vs}
Vb b 0 dc {vdd}

.control
set numdgt=12
option temp=$&temp
altermod pmos vth0=$&vth0
altermod pmos toxe=$&toxe
altermod pmos ndep=$&ndep
altermod pmos u0=$&u0
altermod pmos xj=$&xj
op
print i(Vd) i(Vg) i(Vs) i(Vb)
.endc
.end
