* pmos_off: single PMOS, one sample
.include ../../models/32nm_HP.pm
.options gmin=1e-18 abstol=1e-18 reltol=1e-6 vntol=1e-9
.temp 46.4646

M1 d g s b pmos W=2.260355e-07 L=3.200000e-08 AD=1.446627e-14 AS=1.446627e-14 PD=5.800710e-07 PS=5.800710e-07
Vd d 0 dc 0.822072
Vg g 0 dc 0.9438
Vs s 0 dc 0.738409
Vb b 0 dc 0.9438

.control
altermod pmos vth0=-5.391312807e-01
altermod pmos toxe=1.220891178e-09
altermod pmos ndep=3.218089873e+18
altermod pmos u0=1.281799800e-02
altermod pmos xj=9.834137109e-09
op
print i(Vd) i(Vg) i(Vs) i(Vb)
.endc
.end
