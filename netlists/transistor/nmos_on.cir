* nmos_on: single NMOS, one sample
.include ../../models/32nm_HP.pm
.options gmin=1e-18 abstol=1e-18 reltol=1e-6 vntol=1e-9
.temp -34.6798

M1 d g s b nmos W=2.479069e-07 L=3.200000e-08 AD=1.586604e-14 AS=1.586604e-14 PD=6.238139e-07 PS=6.238139e-07
Vd d 0 dc 0.318409
Vg g 0 dc 0.878884
Vs s 0 dc 0.284666
Vb b 0 dc 0

.control
altermod nmos vth0=4.796151865e-01
altermod nmos toxe=1.103631394e-09
altermod nmos ndep=4.037200415e+18
altermod nmos u0=5.278352079e-02
altermod nmos xj=1.037339106e-08
op
print i(Vd) i(Vg) i(Vs) i(Vb)
.endc
.end
